# Ansys Electronics Desktop project, version 2020.2
materials:
  vacuum: permittivity=1
  pec: conductivity=1e+30
  PMLGroup1_Z_1: permittivity{anisotropic component1=1.3728277 component2=1.3728277 component3=0.36421177} permeability{anisotropic component1=1.3728277 component2=1.3728277 component3=0.36421177} dielectric_loss_tangent{anisotropic component1=1 component2=1 component3=-1} magnetic_loss_tangent{anisotropic component1=1 component2=1 component3=-1}
  PMLGroup1_XZ_1: permittivity{anisotropic component1=1 component2=0.01 component3=1} permeability{anisotropic component1=1 component2=0.01 component3=1} dielectric_loss_tangent{anisotropic component1=0 component2=376.93116 component3=0} magnetic_loss_tangent{anisotropic component1=0 component2=376.93116 component3=0}
  PMLGroup1_YZ_1: permittivity{anisotropic component1=0.01 component2=1 component3=1} permeability{anisotropic component1=0.01 component2=1 component3=1} dielectric_loss_tangent{anisotropic component1=376.93116 component2=0 component3=0} magnetic_loss_tangent{anisotropic component1=376.93116 component2=0 component3=0}
  PMLGroup1_XYZ_1: permittivity{anisotropic component1=1.3728277 component2=1.3728277 component3=1.3728277} permeability{anisotropic component1=1.3728277 component2=1.3728277 component3=1.3728277} dielectric_loss_tangent{anisotropic component1=1 component2=1 component3=1} magnetic_loss_tangent{anisotropic component1=1 component2=1 component3=1}

design HFSSDesign1 (HFSS, DrivenModal, model units mm)
variables:
  dR = 1mm
  dL = 54mm
  gL = 1mm
geometry:
  Dipole [pec] = cylinder(axis=Z, base_centre=(0mm, 0mm, -dL/2), radius=dR, height=dL)
  gap [vacuum] = cylinder(axis=Z, base_centre=(0mm, 0mm, -gL/2), radius=dR, height=gL)
  gap_1 = gap.copy()
  Dipole.subtract(gap_1)
  p1 = gap.section(plane=YZ)
  RadiatingSurface [vacuum] = region(absolute_offset=30mm on all sides)
  coordinate_system FaceCS1 = face of RadiatingSurface: Origin=RadiatingSurface.vertex(1 of 8) FaceID=RadiatingSurface.face(+z) AxisPosn=RadiatingSurface.vertex(2 of 8) WhichAxis=X ZRotationAngle=0deg XOffset=0mm YOffset=0mm
  PML_RadiatingSurface_1 [PMLGroup1_Z_1, oriented by FaceCS1] = sweep_along_normal(RadiatingSurface.face(+z), length=39.085145mm)
  coordinate_system FaceCS2 = face of RadiatingSurface: Origin=RadiatingSurface.vertex(5 of 8) FaceID=RadiatingSurface.face(-z) AxisPosn=RadiatingSurface.vertex(6 of 8) WhichAxis=X ZRotationAngle=0deg XOffset=0mm YOffset=0mm
  PML_RadiatingSurface_2 [PMLGroup1_Z_1, oriented by FaceCS2] = sweep_along_normal(RadiatingSurface.face(-z), length=39.085145mm)
  coordinate_system FaceCS3 = face of RadiatingSurface: Origin=RadiatingSurface.vertex(4 of 8) FaceID=RadiatingSurface.face(-y) AxisPosn=RadiatingSurface.vertex(7 of 8) WhichAxis=X ZRotationAngle=0deg XOffset=0mm YOffset=0mm
  PML_RadiatingSurface_3 [PMLGroup1_Z_1, oriented by FaceCS3] = sweep_along_normal(RadiatingSurface.face(-y), length=39.085145mm)
  coordinate_system FaceCS4 = face of RadiatingSurface: Origin=RadiatingSurface.vertex(3 of 8) FaceID=RadiatingSurface.face(-x) AxisPosn=RadiatingSurface.vertex(8 of 8) WhichAxis=X ZRotationAngle=0deg XOffset=0mm YOffset=0mm
  PML_RadiatingSurface_4 [PMLGroup1_Z_1, oriented by FaceCS4] = sweep_along_normal(RadiatingSurface.face(-x), length=39.085145mm)
  coordinate_system FaceCS5 = face of RadiatingSurface: Origin=RadiatingSurface.vertex(2 of 8) FaceID=RadiatingSurface.face(+y) AxisPosn=RadiatingSurface.vertex(5 of 8) WhichAxis=X ZRotationAngle=0deg XOffset=0mm YOffset=0mm
  PML_RadiatingSurface_5 [PMLGroup1_Z_1, oriented by FaceCS5] = sweep_along_normal(RadiatingSurface.face(+y), length=39.085145mm)
  coordinate_system FaceCS6 = face of RadiatingSurface: Origin=RadiatingSurface.vertex(1 of 8) FaceID=RadiatingSurface.face(+x) AxisPosn=RadiatingSurface.vertex(6 of 8) WhichAxis=X ZRotationAngle=0deg XOffset=0mm YOffset=0mm
  PML_RadiatingSurface_6 [PMLGroup1_Z_1, oriented by FaceCS6] = sweep_along_normal(RadiatingSurface.face(+x), length=39.085145mm)
  PML_RadiatingSurface_7 [PMLGroup1_XZ_1, oriented by FaceCS3] = sweep_along_normal(PML_RadiatingSurface_1.face(at (0, -31, 76.5426)), length=39.085145mm)
  PML_RadiatingSurface_8 [PMLGroup1_XZ_1, oriented by FaceCS4] = sweep_along_normal(PML_RadiatingSurface_1.face(at (-31, 0, 76.5426)), length=39.085145mm)
  PML_RadiatingSurface_9 [PMLGroup1_XZ_1, oriented by FaceCS5] = sweep_along_normal(PML_RadiatingSurface_1.face(at (0, 31, 76.5426)), length=39.085145mm)
  PML_RadiatingSurface_10 [PMLGroup1_YZ_1, oriented by FaceCS1] = sweep_along_normal(PML_RadiatingSurface_1.face(at (31, 0, 76.5426)), length=39.085145mm)
  coordinate_system FaceCS7 = face of RadiatingSurface: Origin=RadiatingSurface.vertex(6 of 8) FaceID=RadiatingSurface.face(-z) AxisPosn=RadiatingSurface.vertex(7 of 8) WhichAxis=X ZRotationAngle=0deg XOffset=0mm YOffset=0mm
  PML_RadiatingSurface_11 [PMLGroup1_YZ_1, oriented by FaceCS7] = sweep_along_normal(PML_RadiatingSurface_2.face(at (0, -31, -76.5426)), length=39.085145mm)
  coordinate_system FaceCS8 = face of RadiatingSurface: Origin=RadiatingSurface.vertex(7 of 8) FaceID=RadiatingSurface.face(-z) AxisPosn=RadiatingSurface.vertex(8 of 8) WhichAxis=X ZRotationAngle=0deg XOffset=0mm YOffset=0mm
  PML_RadiatingSurface_12 [PMLGroup1_YZ_1, oriented by FaceCS8] = sweep_along_normal(PML_RadiatingSurface_2.face(at (-31, 0, -76.5426)), length=39.085145mm)
  PML_RadiatingSurface_13 [PMLGroup1_XZ_1, oriented by FaceCS2] = sweep_along_normal(PML_RadiatingSurface_2.face(at (0, 31, -76.5426)), length=39.085145mm)
  PML_RadiatingSurface_14 [PMLGroup1_YZ_1, oriented by FaceCS2] = sweep_along_normal(PML_RadiatingSurface_2.face(at (31, 0, -76.5426)), length=39.085145mm)
  PML_RadiatingSurface_15 [PMLGroup1_YZ_1, oriented by FaceCS3] = sweep_along_normal(PML_RadiatingSurface_3.face(at (-31, -50.5426, 0)), length=39.085145mm)
  PML_RadiatingSurface_16 [PMLGroup1_YZ_1, oriented by FaceCS6] = sweep_along_normal(PML_RadiatingSurface_3.face(at (31, -50.5426, 0)), length=39.085145mm)
  PML_RadiatingSurface_17 [PMLGroup1_YZ_1, oriented by FaceCS4] = sweep_along_normal(PML_RadiatingSurface_4.face(at (-50.5426, 31, 0)), length=39.085145mm)
  PML_RadiatingSurface_18 [PMLGroup1_YZ_1, oriented by FaceCS5] = sweep_along_normal(PML_RadiatingSurface_5.face(at (31, 50.5426, 0)), length=39.085145mm)
  PML_RadiatingSurface_19 [PMLGroup1_XYZ_1, oriented by FaceCS3] = sweep_along_normal(PML_RadiatingSurface_7.face(at (-31, -50.5426, 76.5426)), length=39.085145mm)
  PML_RadiatingSurface_20 [PMLGroup1_XYZ_1, oriented by FaceCS1] = sweep_along_normal(PML_RadiatingSurface_7.face(at (31, -50.5426, 76.5426)), length=39.085145mm)
  PML_RadiatingSurface_21 [PMLGroup1_XYZ_1, oriented by FaceCS4] = sweep_along_normal(PML_RadiatingSurface_8.face(at (-50.5426, 31, 76.5426)), length=39.085145mm)
  PML_RadiatingSurface_22 [PMLGroup1_XYZ_1, oriented by FaceCS5] = sweep_along_normal(PML_RadiatingSurface_9.face(at (31, 50.5426, 76.5426)), length=39.085145mm)
  PML_RadiatingSurface_23 [PMLGroup1_XYZ_1, oriented by FaceCS8] = sweep_along_normal(PML_RadiatingSurface_11.face(at (-31, -50.5426, -76.5426)), length=39.085145mm)
  PML_RadiatingSurface_24 [PMLGroup1_XYZ_1, oriented by FaceCS7] = sweep_along_normal(PML_RadiatingSurface_11.face(at (31, -50.5426, -76.5426)), length=39.085145mm)
  coordinate_system FaceCS9 = face of RadiatingSurface: Origin=RadiatingSurface.vertex(8 of 8) FaceID=RadiatingSurface.face(-z) AxisPosn=RadiatingSurface.vertex(5 of 8) WhichAxis=X ZRotationAngle=0deg XOffset=0mm YOffset=0mm
  PML_RadiatingSurface_25 [PMLGroup1_XYZ_1, oriented by FaceCS9] = sweep_along_normal(PML_RadiatingSurface_12.face(at (-50.5426, 31, -76.5426)), length=39.085145mm)
  PML_RadiatingSurface_26 [PMLGroup1_XYZ_1, oriented by FaceCS2] = sweep_along_normal(PML_RadiatingSurface_13.face(at (31, 50.5426, -76.5426)), length=39.085145mm)
boundaries and excitations:
  PML_radiation1: Radiation Faces=RadiatingSurface.face(+z) IsForPML
  PML_radiation2: Radiation Faces=RadiatingSurface.face(-z) IsForPML
  PML_radiation3: Radiation Faces=RadiatingSurface.face(-y) IsForPML
  PML_radiation4: Radiation Faces=RadiatingSurface.face(-x) IsForPML
  PML_radiation5: Radiation Faces=RadiatingSurface.face(+y) IsForPML
  PML_radiation6: Radiation Faces=RadiatingSurface.face(+x) IsForPML
  1: Lumped Port Objects=p1 Modes{Mode1{IntLine{middle of p1.edge(at (0, 0, -0.5)) -> middle of p1.edge(at (0, 0, 0.5))} CharImp=Zpi RenormImp=73ohm}} Impedance=50ohm
setups:
  2G5Hz: HfssDriven Frequency=2.5GHz MaxDeltaS=0.02 MaximumPasses=6 MinimumPasses=1 MinimumConvergedPasses=1 PercentRefinement=30 BasisOrder=1 PortAccuracy=2
    sweep Sweep: 1.25GHz to 3.75GHz, 401 points; Type=Interpolating InterpTolerance=0.5 InterpMaxSolns=250 InterpUsePortImped=false PassivityErrorTolerance=0.0001
source amplitudes:
  1:1: 1W 0deg
optimetrics:
  ParametricSetup1: Parametric Sim._Setups=[2G5Hz]
    sweep dL: LIN 52mm 58mm 1mm
  ParametricSetup2: Parametric Sim._Setups=[2G5Hz]
    sweep dR: LIN 0.5mm 5.5mm 1mm
  ParametricSetup3: Parametric Sim._Setups=[2G5Hz]
    sweep gL: LIN 0.5mm 1.5mm 0.5mm
radiation setups:
  3D: Infinite Sphere Theta=0deg..180deg step 2deg Phi=-180deg..180deg step 2deg
  Elevation: Infinite Sphere Theta=-180deg..180deg step 1deg Phi=0deg..90deg step 90deg
  Azimuth: Infinite Sphere Theta=90deg..90deg step 0deg Phi=-180deg..180deg step 1deg
  3D1: Infinite Sphere Theta=0deg..180deg step 1deg Phi=-180deg..180deg step 1deg
  P_Plane: Infinite Sphere Theta=-180deg..180deg step 1deg Phi=0deg..0deg step 0deg
reports:
  Z-parameter-2.5GHz: re(Z(1,1)), im(Z(1,1)) vs Freq on 2G5Hz : Sweep
  S-parameter-2.5GHz: dB(S(1,1)) vs Freq on 2G5Hz : Sweep; markers m1 at 2.5125GHz
  Cutplane Gain-2.5GHz: dB(GainTotal) vs Theta on 2G5Hz : LastAdaptive, P_Plane [Phi=all Freq=2.5GHz]
  Directivity Plot 1: dB(DirTotal) vs Phi, Theta on 2G5Hz : LastAdaptive, 3D [Freq=2.5GHz]
  S-parameter-L-dependence: dB(S(1,1)) vs Freq on 2G5Hz : Sweep [dL=all]
  S-parameter-R-dependence: dB(S(1,1)) vs Freq on 2G5Hz : Sweep [dR=all dL=55mm]
